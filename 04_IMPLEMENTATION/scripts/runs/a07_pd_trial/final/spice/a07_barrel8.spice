* NGSPICE file created from a07_barrel8.ext - technology: sky130A

* Black-box entry subcircuit for sky130_fd_sc_hd__decap_3 abstract view
.subckt sky130_fd_sc_hd__decap_3 VGND VNB VPB VPWR
.ends

* Black-box entry subcircuit for sky130_fd_sc_hd__fill_1 abstract view
.subckt sky130_fd_sc_hd__fill_1 VGND VNB VPB VPWR
.ends

* Black-box entry subcircuit for sky130_fd_sc_hd__a21oi_2 abstract view
.subckt sky130_fd_sc_hd__a21oi_2 A1 A2 B1 VGND VNB VPB VPWR Y
.ends

* Black-box entry subcircuit for sky130_fd_sc_hd__clkdlybuf4s25_1 abstract view
.subckt sky130_fd_sc_hd__clkdlybuf4s25_1 A VGND VNB VPB VPWR X
.ends

* Black-box entry subcircuit for sky130_fd_sc_hd__mux2_1 abstract view
.subckt sky130_fd_sc_hd__mux2_1 A0 A1 S VGND VNB VPB VPWR X
.ends

* Black-box entry subcircuit for sky130_fd_sc_hd__and2b_2 abstract view
.subckt sky130_fd_sc_hd__and2b_2 A_N B VGND VNB VPB VPWR X
.ends

* Black-box entry subcircuit for sky130_fd_sc_hd__tapvpwrvgnd_1 abstract view
.subckt sky130_fd_sc_hd__tapvpwrvgnd_1 VGND VPWR
.ends

* Black-box entry subcircuit for sky130_fd_sc_hd__fill_2 abstract view
.subckt sky130_fd_sc_hd__fill_2 VGND VNB VPB VPWR
.ends

* Black-box entry subcircuit for sky130_fd_sc_hd__and2_2 abstract view
.subckt sky130_fd_sc_hd__and2_2 A B VGND VNB VPB VPWR X
.ends

* Black-box entry subcircuit for sky130_fd_sc_hd__o2bb2a_2 abstract view
.subckt sky130_fd_sc_hd__o2bb2a_2 A1_N A2_N B1 B2 VGND VNB VPB VPWR X
.ends

* Black-box entry subcircuit for sky130_fd_sc_hd__a31o_2 abstract view
.subckt sky130_fd_sc_hd__a31o_2 A1 A2 A3 B1 VGND VNB VPB VPWR X
.ends

* Black-box entry subcircuit for sky130_fd_sc_hd__o22ai_2 abstract view
.subckt sky130_fd_sc_hd__o22ai_2 A1 A2 B1 B2 VGND VNB VPB VPWR Y
.ends

* Black-box entry subcircuit for sky130_fd_sc_hd__or3_2 abstract view
.subckt sky130_fd_sc_hd__or3_2 A B C VGND VNB VPB VPWR X
.ends

* Black-box entry subcircuit for sky130_fd_sc_hd__nor2_2 abstract view
.subckt sky130_fd_sc_hd__nor2_2 A B VGND VNB VPB VPWR Y
.ends

* Black-box entry subcircuit for sky130_fd_sc_hd__o32a_2 abstract view
.subckt sky130_fd_sc_hd__o32a_2 A1 A2 A3 B1 B2 VGND VNB VPB VPWR X
.ends

* Black-box entry subcircuit for sky130_fd_sc_hd__and3_2 abstract view
.subckt sky130_fd_sc_hd__and3_2 A B C VGND VNB VPB VPWR X
.ends

* Black-box entry subcircuit for sky130_fd_sc_hd__a311o_2 abstract view
.subckt sky130_fd_sc_hd__a311o_2 A1 A2 A3 B1 C1 VGND VNB VPB VPWR X
.ends

* Black-box entry subcircuit for sky130_fd_sc_hd__nand2_2 abstract view
.subckt sky130_fd_sc_hd__nand2_2 A B VGND VNB VPB VPWR Y
.ends

* Black-box entry subcircuit for sky130_fd_sc_hd__o22a_2 abstract view
.subckt sky130_fd_sc_hd__o22a_2 A1 A2 B1 B2 VGND VNB VPB VPWR X
.ends

* Black-box entry subcircuit for sky130_fd_sc_hd__a2bb2o_2 abstract view
.subckt sky130_fd_sc_hd__a2bb2o_2 A1_N A2_N B1 B2 VGND VNB VPB VPWR X
.ends

* Black-box entry subcircuit for sky130_fd_sc_hd__o21ai_2 abstract view
.subckt sky130_fd_sc_hd__o21ai_2 A1 A2 B1 VGND VNB VPB VPWR Y
.ends

* Black-box entry subcircuit for sky130_fd_sc_hd__nand3_2 abstract view
.subckt sky130_fd_sc_hd__nand3_2 A B C VGND VNB VPB VPWR Y
.ends

* Black-box entry subcircuit for sky130_fd_sc_hd__inv_2 abstract view
.subckt sky130_fd_sc_hd__inv_2 A VGND VNB VPB VPWR Y
.ends

* Black-box entry subcircuit for sky130_fd_sc_hd__o21a_2 abstract view
.subckt sky130_fd_sc_hd__o21a_2 A1 A2 B1 VGND VNB VPB VPWR X
.ends

* Black-box entry subcircuit for sky130_fd_sc_hd__a21o_2 abstract view
.subckt sky130_fd_sc_hd__a21o_2 A1 A2 B1 VGND VNB VPB VPWR X
.ends

.subckt a07_barrel8 VGND VPWR din[0] din[1] din[2] din[3] din[4] din[5] din[6] din[7]
+ dout[0] dout[1] dout[2] dout[3] dout[4] dout[5] dout[6] dout[7] mode[0] mode[1]
+ shamt[0] shamt[1] shamt[2]
XFILLER_12_21 VGND VGND VPWR VPWR sky130_fd_sc_hd__decap_3
XFILLER_12_32 VGND VGND VPWR VPWR sky130_fd_sc_hd__decap_3
XFILLER_3_34 VGND VGND VPWR VPWR sky130_fd_sc_hd__decap_3
XFILLER_0_24 VGND VGND VPWR VPWR sky130_fd_sc_hd__decap_3
XFILLER_0_57 VGND VGND VPWR VPWR sky130_fd_sc_hd__decap_3
XFILLER_9_11 VGND VGND VPWR VPWR sky130_fd_sc_hd__decap_3
XFILLER_9_55 VGND VGND VPWR VPWR sky130_fd_sc_hd__fill_1
X_062_ _093_/B _061_/X _060_/X VGND VGND VPWR VPWR _087_/C sky130_fd_sc_hd__a21oi_2
XFILLER_6_23 VGND VGND VPWR VPWR sky130_fd_sc_hd__decap_3
XFILLER_6_45 VGND VGND VPWR VPWR sky130_fd_sc_hd__decap_3
XPHY_EDGE_ROW_12_Left_25 VGND VGND VPWR VPWR sky130_fd_sc_hd__decap_3
XFILLER_3_24 VGND VGND VPWR VPWR sky130_fd_sc_hd__fill_1
XFILLER_3_57 VGND VGND VPWR VPWR sky130_fd_sc_hd__decap_3
Xoutput20 _086_/X VGND VGND VPWR VPWR dout[6] sky130_fd_sc_hd__clkdlybuf4s25_1
XFILLER_12_11 VGND VGND VPWR VPWR sky130_fd_sc_hd__decap_3
XFILLER_12_44 VGND VGND VPWR VPWR sky130_fd_sc_hd__fill_1
XPHY_EDGE_ROW_0_Left_13 VGND VGND VPWR VPWR sky130_fd_sc_hd__decap_3
XPHY_EDGE_ROW_12_Right_12 VGND VGND VPWR VPWR sky130_fd_sc_hd__decap_3
XFILLER_9_23 VGND VGND VPWR VPWR sky130_fd_sc_hd__decap_3
X_061_ _052_/A _074_/B _099_/A VGND VGND VPWR VPWR _061_/X sky130_fd_sc_hd__mux2_1
XFILLER_6_57 VGND VGND VPWR VPWR sky130_fd_sc_hd__decap_3
XPHY_EDGE_ROW_6_Right_6 VGND VGND VPWR VPWR sky130_fd_sc_hd__decap_3
Xoutput21 _073_/X VGND VGND VPWR VPWR dout[7] sky130_fd_sc_hd__clkdlybuf4s25_1
XFILLER_0_37 VGND VGND VPWR VPWR sky130_fd_sc_hd__decap_3
XFILLER_3_3 VGND VGND VPWR VPWR sky130_fd_sc_hd__decap_3
XFILLER_9_35 VGND VGND VPWR VPWR sky130_fd_sc_hd__decap_3
XFILLER_9_57 VGND VGND VPWR VPWR sky130_fd_sc_hd__decap_3
X_060_ _093_/B _093_/C VGND VGND VPWR VPWR _060_/X sky130_fd_sc_hd__and2b_2
XTAP_TAPCELL_ROW_8_35 VGND VPWR sky130_fd_sc_hd__tapvpwrvgnd_1
XFILLER_6_14 VGND VGND VPWR VPWR sky130_fd_sc_hd__decap_3
XFILLER_6_36 VGND VGND VPWR VPWR sky130_fd_sc_hd__decap_3
XFILLER_12_24 VGND VGND VPWR VPWR sky130_fd_sc_hd__decap_3
XFILLER_12_35 VGND VGND VPWR VPWR sky130_fd_sc_hd__decap_3
XFILLER_12_57 VGND VGND VPWR VPWR sky130_fd_sc_hd__decap_3
XFILLER_3_15 VGND VGND VPWR VPWR sky130_fd_sc_hd__decap_3
XFILLER_3_37 VGND VGND VPWR VPWR sky130_fd_sc_hd__decap_3
XFILLER_0_27 VGND VGND VPWR VPWR sky130_fd_sc_hd__fill_1
XFILLER_9_14 VGND VGND VPWR VPWR sky130_fd_sc_hd__decap_3
XFILLER_6_26 VGND VGND VPWR VPWR sky130_fd_sc_hd__fill_2
XFILLER_6_48 VGND VGND VPWR VPWR sky130_fd_sc_hd__decap_3
XFILLER_11_3 VGND VGND VPWR VPWR sky130_fd_sc_hd__decap_3
XFILLER_12_14 VGND VGND VPWR VPWR sky130_fd_sc_hd__fill_2
XFILLER_9_26 VGND VGND VPWR VPWR sky130_fd_sc_hd__decap_3
XPHY_EDGE_ROW_4_Left_17 VGND VGND VPWR VPWR sky130_fd_sc_hd__decap_3
XPHY_EDGE_ROW_7_Left_20 VGND VGND VPWR VPWR sky130_fd_sc_hd__decap_3
XFILLER_1_3 VGND VGND VPWR VPWR sky130_fd_sc_hd__decap_3
XFILLER_9_38 VGND VGND VPWR VPWR sky130_fd_sc_hd__fill_2
XFILLER_9_49 VGND VGND VPWR VPWR sky130_fd_sc_hd__decap_3
XFILLER_10_70 VGND VGND VPWR VPWR sky130_fd_sc_hd__decap_3
XFILLER_6_17 VGND VGND VPWR VPWR sky130_fd_sc_hd__decap_3
XFILLER_6_39 VGND VGND VPWR VPWR sky130_fd_sc_hd__decap_3
XFILLER_3_18 VGND VGND VPWR VPWR sky130_fd_sc_hd__decap_3
Xoutput14 _107_/X VGND VGND VPWR VPWR dout[0] sky130_fd_sc_hd__clkdlybuf4s25_1
XTAP_TAPCELL_ROW_2_29 VGND VPWR sky130_fd_sc_hd__tapvpwrvgnd_1
XFILLER_12_27 VGND VGND VPWR VPWR sky130_fd_sc_hd__fill_1
XFILLER_12_38 VGND VGND VPWR VPWR sky130_fd_sc_hd__decap_3
XFILLER_4_50 VGND VGND VPWR VPWR sky130_fd_sc_hd__decap_3
XFILLER_9_17 VGND VGND VPWR VPWR sky130_fd_sc_hd__decap_3
XFILLER_1_73 VGND VGND VPWR VPWR sky130_fd_sc_hd__fill_2
X_099_ _099_/A _099_/B VGND VGND VPWR VPWR _099_/X sky130_fd_sc_hd__and2_2
XFILLER_11_6 VGND VGND VPWR VPWR sky130_fd_sc_hd__fill_1
XFILLER_6_29 VGND VGND VPWR VPWR sky130_fd_sc_hd__fill_2
XPHY_EDGE_ROW_1_Right_1 VGND VGND VPWR VPWR sky130_fd_sc_hd__decap_3
Xoutput15 _105_/X VGND VGND VPWR VPWR dout[1] sky130_fd_sc_hd__clkdlybuf4s25_1
XTAP_TAPCELL_ROW_12_39 VGND VPWR sky130_fd_sc_hd__tapvpwrvgnd_1
XFILLER_9_29 VGND VGND VPWR VPWR sky130_fd_sc_hd__fill_1
XFILLER_10_50 VGND VGND VPWR VPWR sky130_fd_sc_hd__decap_3
X_098_ _055_/X _095_/X _097_/X _099_/B VGND VGND VPWR VPWR _098_/X sky130_fd_sc_hd__o2bb2a_2
XFILLER_7_73 VGND VGND VPWR VPWR sky130_fd_sc_hd__fill_2
Xoutput16 _103_/X VGND VGND VPWR VPWR dout[2] sky130_fd_sc_hd__clkdlybuf4s25_1
XTAP_TAPCELL_ROW_3_30 VGND VPWR sky130_fd_sc_hd__tapvpwrvgnd_1
XFILLER_12_29 VGND VGND VPWR VPWR sky130_fd_sc_hd__decap_3
XFILLER_4_74 VGND VGND VPWR VPWR sky130_fd_sc_hd__fill_1
X_097_ _099_/A _095_/B _080_/X _096_/Y VGND VGND VPWR VPWR _097_/X sky130_fd_sc_hd__a31o_2
XFILLER_10_62 VGND VGND VPWR VPWR sky130_fd_sc_hd__fill_1
XFILLER_10_73 VGND VGND VPWR VPWR sky130_fd_sc_hd__fill_2
XPHY_EDGE_ROW_11_Left_24 VGND VGND VPWR VPWR sky130_fd_sc_hd__decap_3
Xoutput17 _101_/X VGND VGND VPWR VPWR dout[3] sky130_fd_sc_hd__clkdlybuf4s25_1
XFILLER_7_52 VGND VGND VPWR VPWR sky130_fd_sc_hd__decap_3
XFILLER_4_53 VGND VGND VPWR VPWR sky130_fd_sc_hd__decap_3
X_096_ _089_/B _076_/Y _085_/B _095_/B VGND VGND VPWR VPWR _096_/Y sky130_fd_sc_hd__o22ai_2
XFILLER_7_42 VGND VGND VPWR VPWR sky130_fd_sc_hd__fill_2
XPHY_EDGE_ROW_5_Right_5 VGND VGND VPWR VPWR sky130_fd_sc_hd__decap_3
Xoutput18 _098_/X VGND VGND VPWR VPWR dout[4] sky130_fd_sc_hd__clkdlybuf4s25_1
X_079_ _068_/B _054_/C _099_/A VGND VGND VPWR VPWR _079_/X sky130_fd_sc_hd__mux2_1
XFILLER_4_32 VGND VGND VPWR VPWR sky130_fd_sc_hd__decap_3
XFILLER_1_55 VGND VGND VPWR VPWR sky130_fd_sc_hd__fill_1
X_095_ _099_/A _095_/B _095_/C VGND VGND VPWR VPWR _095_/X sky130_fd_sc_hd__or3_2
Xoutput19 _092_/X VGND VGND VPWR VPWR dout[5] sky130_fd_sc_hd__clkdlybuf4s25_1
X_078_ _099_/A _078_/B VGND VGND VPWR VPWR _078_/Y sky130_fd_sc_hd__nor2_2
XPHY_EDGE_ROW_11_Right_11 VGND VGND VPWR VPWR sky130_fd_sc_hd__decap_3
X_094_ _051_/Y _052_/A _093_/X VGND VGND VPWR VPWR _095_/C sky130_fd_sc_hd__a21oi_2
XFILLER_7_33 VGND VGND VPWR VPWR sky130_fd_sc_hd__decap_3
XFILLER_7_55 VGND VGND VPWR VPWR sky130_fd_sc_hd__fill_1
X_077_ _093_/B _052_/Y _089_/B _076_/Y _095_/B VGND VGND VPWR VPWR _078_/B sky130_fd_sc_hd__o32a_2
XTAP_TAPCELL_ROW_6_33 VGND VPWR sky130_fd_sc_hd__tapvpwrvgnd_1
XFILLER_4_56 VGND VGND VPWR VPWR sky130_fd_sc_hd__fill_2
XPHY_EDGE_ROW_3_Left_16 VGND VGND VPWR VPWR sky130_fd_sc_hd__decap_3
X_093_ _099_/A _093_/B _093_/C VGND VGND VPWR VPWR _093_/X sky130_fd_sc_hd__and3_2
Xinput1 din[0] VGND VGND VPWR VPWR _052_/A sky130_fd_sc_hd__clkdlybuf4s25_1
X_076_ _093_/B _075_/X _074_/X VGND VGND VPWR VPWR _076_/Y sky130_fd_sc_hd__a21oi_2
X_059_ _093_/B _058_/X _057_/X VGND VGND VPWR VPWR _089_/A sky130_fd_sc_hd__a21oi_2
XPHY_EDGE_ROW_9_Right_9 VGND VGND VPWR VPWR sky130_fd_sc_hd__decap_3
XFILLER_4_35 VGND VGND VPWR VPWR sky130_fd_sc_hd__decap_3
Xinput2 din[1] VGND VGND VPWR VPWR _093_/C sky130_fd_sc_hd__clkdlybuf4s25_1
X_092_ _055_/X _087_/X _091_/X _099_/B VGND VGND VPWR VPWR _092_/X sky130_fd_sc_hd__o2bb2a_2
X_075_ _093_/C _057_/B _099_/A VGND VGND VPWR VPWR _075_/X sky130_fd_sc_hd__mux2_1
X_058_ _074_/B _082_/B _099_/A VGND VGND VPWR VPWR _058_/X sky130_fd_sc_hd__mux2_1
XTAP_TAPCELL_ROW_0_26 VGND VPWR sky130_fd_sc_hd__tapvpwrvgnd_1
XFILLER_1_15 VGND VGND VPWR VPWR sky130_fd_sc_hd__decap_3
XFILLER_1_37 VGND VGND VPWR VPWR sky130_fd_sc_hd__decap_3
Xinput3 din[2] VGND VGND VPWR VPWR _074_/B sky130_fd_sc_hd__clkdlybuf4s25_1
X_091_ _099_/A _095_/B _067_/X _088_/Y _089_/Y VGND VGND VPWR VPWR _091_/X sky130_fd_sc_hd__a311o_2
X_074_ _093_/B _074_/B VGND VGND VPWR VPWR _074_/X sky130_fd_sc_hd__and2b_2
XFILLER_7_36 VGND VGND VPWR VPWR sky130_fd_sc_hd__decap_3
XPHY_EDGE_ROW_0_Right_0 VGND VGND VPWR VPWR sky130_fd_sc_hd__decap_3
X_057_ _093_/B _057_/B VGND VGND VPWR VPWR _057_/X sky130_fd_sc_hd__and2b_2
XTAP_TAPCELL_ROW_0_27 VGND VPWR sky130_fd_sc_hd__tapvpwrvgnd_1
XFILLER_6_3 VGND VGND VPWR VPWR sky130_fd_sc_hd__fill_2
Xinput4 din[3] VGND VGND VPWR VPWR _057_/B sky130_fd_sc_hd__clkdlybuf4s25_1
X_090_ _099_/A _095_/B VGND VGND VPWR VPWR _090_/Y sky130_fd_sc_hd__nand2_2
XTAP_TAPCELL_ROW_9_36 VGND VPWR sky130_fd_sc_hd__tapvpwrvgnd_1
XFILLER_10_36 VGND VGND VPWR VPWR sky130_fd_sc_hd__decap_3
X_073_ _056_/Y _065_/Y _072_/X _099_/B VGND VGND VPWR VPWR _073_/X sky130_fd_sc_hd__o22a_2
X_056_ _099_/B _056_/B VGND VGND VPWR VPWR _056_/Y sky130_fd_sc_hd__nand2_2
XFILLER_4_16 VGND VGND VPWR VPWR sky130_fd_sc_hd__decap_3
XFILLER_4_38 VGND VGND VPWR VPWR sky130_fd_sc_hd__decap_3
Xinput5 din[4] VGND VGND VPWR VPWR _082_/B sky130_fd_sc_hd__clkdlybuf4s25_1
X_072_ _067_/X _071_/Y _095_/B VGND VGND VPWR VPWR _072_/X sky130_fd_sc_hd__mux2_1
XTAP_TAPCELL_ROW_10_37 VGND VPWR sky130_fd_sc_hd__tapvpwrvgnd_1
XPHY_EDGE_ROW_10_Left_23 VGND VGND VPWR VPWR sky130_fd_sc_hd__decap_3
X_055_ _099_/B _056_/B VGND VGND VPWR VPWR _055_/X sky130_fd_sc_hd__and2_2
X_107_ _099_/B _106_/X _099_/X _097_/X VGND VGND VPWR VPWR _107_/X sky130_fd_sc_hd__a2bb2o_2
XFILLER_5_60 VGND VGND VPWR VPWR sky130_fd_sc_hd__decap_3
XFILLER_10_27 VGND VGND VPWR VPWR sky130_fd_sc_hd__fill_1
Xinput6 din[5] VGND VGND VPWR VPWR _068_/B sky130_fd_sc_hd__clkdlybuf4s25_1
X_071_ _099_/A _088_/B _056_/B VGND VGND VPWR VPWR _071_/Y sky130_fd_sc_hd__o21ai_2
XFILLER_7_39 VGND VGND VPWR VPWR sky130_fd_sc_hd__decap_3
XPHY_EDGE_ROW_4_Right_4 VGND VGND VPWR VPWR sky130_fd_sc_hd__decap_3
X_106_ _076_/Y _090_/Y _095_/C _095_/B VGND VGND VPWR VPWR _106_/X sky130_fd_sc_hd__o22a_2
X_054_ _099_/A _054_/B _054_/C VGND VGND VPWR VPWR _056_/B sky130_fd_sc_hd__nand3_2
XFILLER_4_29 VGND VGND VPWR VPWR sky130_fd_sc_hd__decap_3
XFILLER_10_39 VGND VGND VPWR VPWR sky130_fd_sc_hd__decap_3
XFILLER_4_3 VGND VGND VPWR VPWR sky130_fd_sc_hd__decap_3
Xinput7 din[6] VGND VGND VPWR VPWR input7/X sky130_fd_sc_hd__clkdlybuf4s25_1
X_070_ _093_/B _069_/X _068_/X VGND VGND VPWR VPWR _088_/B sky130_fd_sc_hd__a21oi_2
Xinput10 mode[1] VGND VGND VPWR VPWR _054_/B sky130_fd_sc_hd__clkdlybuf4s25_1
X_053_ _099_/A _054_/B _054_/C VGND VGND VPWR VPWR _053_/X sky130_fd_sc_hd__and3_2
XFILLER_4_19 VGND VGND VPWR VPWR sky130_fd_sc_hd__fill_1
X_105_ _099_/B _104_/X _099_/X _091_/X VGND VGND VPWR VPWR _105_/X sky130_fd_sc_hd__a2bb2o_2
Xinput8 din[7] VGND VGND VPWR VPWR _054_/C sky130_fd_sc_hd__clkdlybuf4s25_1
Xinput11 shamt[0] VGND VGND VPWR VPWR _093_/B sky130_fd_sc_hd__clkdlybuf4s25_1
X_104_ _095_/B _087_/C _090_/Y _089_/A VGND VGND VPWR VPWR _104_/X sky130_fd_sc_hd__o22a_2
X_052_ _052_/A VGND VGND VPWR VPWR _052_/Y sky130_fd_sc_hd__inv_2
XFILLER_10_19 VGND VGND VPWR VPWR sky130_fd_sc_hd__fill_1
XFILLER_5_63 VGND VGND VPWR VPWR sky130_fd_sc_hd__decap_3
XPHY_EDGE_ROW_2_Left_15 VGND VGND VPWR VPWR sky130_fd_sc_hd__decap_3
Xinput9 mode[0] VGND VGND VPWR VPWR _099_/A sky130_fd_sc_hd__clkdlybuf4s25_1
XPHY_EDGE_ROW_10_Right_10 VGND VGND VPWR VPWR sky130_fd_sc_hd__decap_3
Xinput12 shamt[1] VGND VGND VPWR VPWR _095_/B sky130_fd_sc_hd__clkdlybuf4s25_1
X_051_ _093_/B VGND VGND VPWR VPWR _051_/Y sky130_fd_sc_hd__inv_2
XFILLER_8_41 VGND VGND VPWR VPWR sky130_fd_sc_hd__decap_3
X_103_ _099_/B _102_/X _099_/X _081_/X VGND VGND VPWR VPWR _103_/X sky130_fd_sc_hd__a2bb2o_2
XTAP_TAPCELL_ROW_4_31 VGND VPWR sky130_fd_sc_hd__tapvpwrvgnd_1
XFILLER_5_20 VGND VGND VPWR VPWR sky130_fd_sc_hd__decap_3
XPHY_EDGE_ROW_8_Right_8 VGND VGND VPWR VPWR sky130_fd_sc_hd__decap_3
XFILLER_2_32 VGND VGND VPWR VPWR sky130_fd_sc_hd__decap_3
XFILLER_4_6 VGND VGND VPWR VPWR sky130_fd_sc_hd__fill_1
Xinput13 shamt[2] VGND VGND VPWR VPWR _099_/B sky130_fd_sc_hd__clkdlybuf4s25_1
X_102_ _085_/B _090_/Y _078_/B VGND VGND VPWR VPWR _102_/X sky130_fd_sc_hd__o21a_2
X_050_ _099_/A VGND VGND VPWR VPWR _063_/A sky130_fd_sc_hd__inv_2
XFILLER_5_32 VGND VGND VPWR VPWR sky130_fd_sc_hd__decap_3
XFILLER_5_54 VGND VGND VPWR VPWR sky130_fd_sc_hd__fill_2
X_101_ _099_/B _100_/X _099_/X _072_/X VGND VGND VPWR VPWR _101_/X sky130_fd_sc_hd__a2bb2o_2
XFILLER_10_3 VGND VGND VPWR VPWR sky130_fd_sc_hd__fill_2
XFILLER_5_66 VGND VGND VPWR VPWR sky130_fd_sc_hd__fill_1
XFILLER_11_54 VGND VGND VPWR VPWR sky130_fd_sc_hd__fill_2
XPHY_EDGE_ROW_6_Left_19 VGND VGND VPWR VPWR sky130_fd_sc_hd__decap_3
X_100_ _088_/B _090_/Y _065_/B VGND VGND VPWR VPWR _100_/X sky130_fd_sc_hd__o21a_2
XFILLER_8_22 VGND VGND VPWR VPWR sky130_fd_sc_hd__decap_3
XFILLER_8_44 VGND VGND VPWR VPWR sky130_fd_sc_hd__decap_3
XPHY_EDGE_ROW_9_Left_22 VGND VGND VPWR VPWR sky130_fd_sc_hd__decap_3
XFILLER_5_23 VGND VGND VPWR VPWR sky130_fd_sc_hd__fill_1
XFILLER_2_35 VGND VGND VPWR VPWR sky130_fd_sc_hd__decap_3
XFILLER_2_57 VGND VGND VPWR VPWR sky130_fd_sc_hd__fill_2
XFILLER_0_3 VGND VGND VPWR VPWR sky130_fd_sc_hd__decap_3
XTAP_TAPCELL_ROW_7_34 VGND VPWR sky130_fd_sc_hd__tapvpwrvgnd_1
XFILLER_5_35 VGND VGND VPWR VPWR sky130_fd_sc_hd__fill_2
XFILLER_5_57 VGND VGND VPWR VPWR sky130_fd_sc_hd__decap_3
XFILLER_11_23 VGND VGND VPWR VPWR sky130_fd_sc_hd__fill_2
XFILLER_11_34 VGND VGND VPWR VPWR sky130_fd_sc_hd__decap_3
XFILLER_8_57 VGND VGND VPWR VPWR sky130_fd_sc_hd__fill_2
X_089_ _089_/A _089_/B VGND VGND VPWR VPWR _089_/Y sky130_fd_sc_hd__nor2_2
XPHY_EDGE_ROW_3_Right_3 VGND VGND VPWR VPWR sky130_fd_sc_hd__decap_3
XFILLER_11_57 VGND VGND VPWR VPWR sky130_fd_sc_hd__fill_2
XFILLER_8_25 VGND VGND VPWR VPWR sky130_fd_sc_hd__decap_3
X_088_ _095_/B _088_/B VGND VGND VPWR VPWR _088_/Y sky130_fd_sc_hd__nor2_2
XFILLER_2_27 VGND VGND VPWR VPWR sky130_fd_sc_hd__fill_1
XFILLER_2_38 VGND VGND VPWR VPWR sky130_fd_sc_hd__decap_3
X_087_ _099_/A _095_/B _087_/C VGND VGND VPWR VPWR _087_/X sky130_fd_sc_hd__or3_2
XTAP_TAPCELL_ROW_1_28 VGND VPWR sky130_fd_sc_hd__tapvpwrvgnd_1
XFILLER_11_37 VGND VGND VPWR VPWR sky130_fd_sc_hd__decap_3
XFILLER_8_38 VGND VGND VPWR VPWR sky130_fd_sc_hd__decap_3
XPHY_EDGE_ROW_1_Left_14 VGND VGND VPWR VPWR sky130_fd_sc_hd__decap_3
X_086_ _099_/B _081_/X _085_/Y _056_/Y _078_/Y VGND VGND VPWR VPWR _086_/X sky130_fd_sc_hd__o32a_2
X_069_ _082_/B input7/X _099_/A VGND VGND VPWR VPWR _069_/X sky130_fd_sc_hd__mux2_1
XFILLER_5_17 VGND VGND VPWR VPWR sky130_fd_sc_hd__decap_3
XFILLER_6_60 VGND VGND VPWR VPWR sky130_fd_sc_hd__decap_3
XPHY_EDGE_ROW_7_Right_7 VGND VGND VPWR VPWR sky130_fd_sc_hd__decap_3
XFILLER_2_29 VGND VGND VPWR VPWR sky130_fd_sc_hd__decap_3
XTAP_TAPCELL_ROW_11_38 VGND VPWR sky130_fd_sc_hd__tapvpwrvgnd_1
X_085_ _089_/B _085_/B VGND VGND VPWR VPWR _085_/Y sky130_fd_sc_hd__nor2_2
XFILLER_0_40 VGND VGND VPWR VPWR sky130_fd_sc_hd__fill_1
XFILLER_9_60 VGND VGND VPWR VPWR sky130_fd_sc_hd__decap_3
X_068_ _093_/B _068_/B VGND VGND VPWR VPWR _068_/X sky130_fd_sc_hd__and2b_2
XFILLER_6_72 VGND VGND VPWR VPWR sky130_fd_sc_hd__decap_3
XFILLER_3_40 VGND VGND VPWR VPWR sky130_fd_sc_hd__decap_3
XFILLER_12_60 VGND VGND VPWR VPWR sky130_fd_sc_hd__decap_3
XFILLER_12_71 VGND VGND VPWR VPWR sky130_fd_sc_hd__decap_3
X_084_ _093_/B _083_/X _082_/X VGND VGND VPWR VPWR _085_/B sky130_fd_sc_hd__a21oi_2
X_067_ _054_/C _093_/B _053_/X _066_/X VGND VGND VPWR VPWR _067_/X sky130_fd_sc_hd__o22a_2
XFILLER_6_51 VGND VGND VPWR VPWR sky130_fd_sc_hd__decap_3
XFILLER_7_3 VGND VGND VPWR VPWR sky130_fd_sc_hd__decap_3
XFILLER_8_19 VGND VGND VPWR VPWR sky130_fd_sc_hd__decap_3
XPHY_EDGE_ROW_5_Left_18 VGND VGND VPWR VPWR sky130_fd_sc_hd__decap_3
X_083_ _057_/B _068_/B _099_/A VGND VGND VPWR VPWR _083_/X sky130_fd_sc_hd__mux2_1
XPHY_EDGE_ROW_8_Left_21 VGND VGND VPWR VPWR sky130_fd_sc_hd__decap_3
X_066_ _063_/A input7/X _051_/Y VGND VGND VPWR VPWR _066_/X sky130_fd_sc_hd__a21o_2
XFILLER_6_63 VGND VGND VPWR VPWR sky130_fd_sc_hd__fill_2
XFILLER_3_31 VGND VGND VPWR VPWR sky130_fd_sc_hd__decap_3
XFILLER_3_53 VGND VGND VPWR VPWR sky130_fd_sc_hd__decap_3
XFILLER_0_21 VGND VGND VPWR VPWR sky130_fd_sc_hd__decap_3
X_082_ _093_/B _082_/B VGND VGND VPWR VPWR _082_/X sky130_fd_sc_hd__and2b_2
X_065_ _099_/A _065_/B VGND VGND VPWR VPWR _065_/Y sky130_fd_sc_hd__nor2_2
XTAP_TAPCELL_ROW_12_40 VGND VPWR sky130_fd_sc_hd__tapvpwrvgnd_1
XFILLER_9_52 VGND VGND VPWR VPWR sky130_fd_sc_hd__decap_3
XFILLER_9_63 VGND VGND VPWR VPWR sky130_fd_sc_hd__decap_3
XFILLER_6_20 VGND VGND VPWR VPWR sky130_fd_sc_hd__decap_3
XFILLER_6_42 VGND VGND VPWR VPWR sky130_fd_sc_hd__decap_3
XFILLER_12_41 VGND VGND VPWR VPWR sky130_fd_sc_hd__decap_3
XFILLER_12_74 VGND VGND VPWR VPWR sky130_fd_sc_hd__fill_1
XFILLER_3_21 VGND VGND VPWR VPWR sky130_fd_sc_hd__decap_3
XFILLER_3_43 VGND VGND VPWR VPWR sky130_fd_sc_hd__fill_1
X_081_ _080_/X _053_/X _095_/B VGND VGND VPWR VPWR _081_/X sky130_fd_sc_hd__mux2_1
XFILLER_9_20 VGND VGND VPWR VPWR sky130_fd_sc_hd__decap_3
X_064_ _095_/B _089_/A _087_/C _089_/B VGND VGND VPWR VPWR _065_/B sky130_fd_sc_hd__o22a_2
XTAP_TAPCELL_ROW_5_32 VGND VPWR sky130_fd_sc_hd__tapvpwrvgnd_1
XFILLER_6_54 VGND VGND VPWR VPWR sky130_fd_sc_hd__decap_3
XPHY_EDGE_ROW_2_Right_2 VGND VGND VPWR VPWR sky130_fd_sc_hd__decap_3
XFILLER_7_6 VGND VGND VPWR VPWR sky130_fd_sc_hd__fill_1
XFILLER_12_53 VGND VGND VPWR VPWR sky130_fd_sc_hd__decap_3
X_080_ input7/X _079_/X _093_/B VGND VGND VPWR VPWR _080_/X sky130_fd_sc_hd__mux2_1
X_063_ _063_/A _095_/B VGND VGND VPWR VPWR _089_/B sky130_fd_sc_hd__nand2_2
.ends
